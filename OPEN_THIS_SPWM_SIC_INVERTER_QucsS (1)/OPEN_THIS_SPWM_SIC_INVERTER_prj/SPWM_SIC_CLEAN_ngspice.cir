* CLEAN THREE-PHASE SPWM SIC INVERTER
* Direct ngspice backup netlist

.include SPWM_SIC_QucsS_Models.lib

VDC DC_POS DC_NEG 750
CDC DC_POS DC_NEG 2200u
VSS DC_NEG 0 0
VEN ENABLE_5V DC_NEG 5

XSPWM DC_NEG PWM_AH PWM_AL PWM_BH PWM_BL PWM_CH PWM_CL
+ VREF_A VREF_B VREF_C VCARRIER
+ SPWM_3PH_QS
+ PARAMS: FOUT=50 FSW=40k MA=0.85 ACAR=1
+ VLOGIC=5 TDEAD=500n ROUT=10

XDRV_A PWM_AH PWM_AL ENABLE_5V DC_NEG
+ GH_A VPOLE_A GL_A DC_NEG
+ SIC_DUAL_GATE_DRIVER
+ PARAMS: VON=18 VOFF=-3.5 TPD=80n

XDRV_B PWM_BH PWM_BL ENABLE_5V DC_NEG
+ GH_B VPOLE_B GL_B DC_NEG
+ SIC_DUAL_GATE_DRIVER
+ PARAMS: VON=18 VOFF=-3.5 TPD=80n

XDRV_C PWM_CH PWM_CL ENABLE_5V DC_NEG
+ GH_C VPOLE_C GL_C DC_NEG
+ SIC_DUAL_GATE_DRIVER
+ PARAMS: VON=18 VOFF=-3.5 TPD=80n

XQAH DC_POS GH_A VPOLE_A VPOLE_A UF3C120040K4S_QS
XQAL VPOLE_A GL_A DC_NEG DC_NEG UF3C120040K4S_QS

XQBH DC_POS GH_B VPOLE_B VPOLE_B UF3C120040K4S_QS
XQBL VPOLE_B GL_B DC_NEG DC_NEG UF3C120040K4S_QS

XQCH DC_POS GH_C VPOLE_C VPOLE_C UF3C120040K4S_QS
XQCL VPOLE_C GL_C DC_NEG DC_NEG UF3C120040K4S_QS

LA VPOLE_A VA_FILT 2m
RLA VA_FILT N_FLOAT 20
RDA VA_FILT NCA 2
CFA NCA N_FLOAT 10u

LB VPOLE_B VB_FILT 2m
RLB VB_FILT N_FLOAT 20
RDB VB_FILT NCB 2
CFB NCB N_FLOAT 10u

LC VPOLE_C VC_FILT 2m
RLC VC_FILT N_FLOAT 20
RDC VC_FILT NCC 2
CFC NCC N_FLOAT 10u

RNEUT N_FLOAT DC_NEG 100Meg

.options method=gear reltol=1e-4 abstol=1p vntol=1u
.tran 200n 60m 0 200n

.meas tran VAB_RMS RMS V(VA_FILT,VB_FILT) FROM=40m TO=60m
.meas tran VBC_RMS RMS V(VB_FILT,VC_FILT) FROM=40m TO=60m
.meas tran VCA_RMS RMS V(VC_FILT,VA_FILT) FROM=40m TO=60m

.meas tran VAN_RMS RMS V(VA_FILT,N_FLOAT) FROM=40m TO=60m
.meas tran VBN_RMS RMS V(VB_FILT,N_FLOAT) FROM=40m TO=60m
.meas tran VCN_RMS RMS V(VC_FILT,N_FLOAT) FROM=40m TO=60m

.meas tran IA_RMS RMS I(LA) FROM=40m TO=60m
.meas tran IB_RMS RMS I(LB) FROM=40m TO=60m
.meas tran IC_RMS RMS I(LC) FROM=40m TO=60m

.plot tran V(VA_FILT,N_FLOAT) V(VB_FILT,N_FLOAT) V(VC_FILT,N_FLOAT)
.plot tran V(VA_FILT,VB_FILT) V(VB_FILT,VC_FILT) V(VC_FILT,VA_FILT)
.plot tran V(PWM_AH) V(PWM_AL) V(GH_A,VPOLE_A) V(GL_A,DC_NEG)

.end
