* =============================================================================
* 800 V DC-link nominal component-level transient
* Open directly in LTspice and select Run.
* =============================================================================
.param VPACK=800 VCOIL=12 VLOGIC=5
.param RBAT=25m LBAT=1u RHAR=22m LHAR=2u
.param RPRE25=92 TCRPRE=100u TEMPAMB=25
.param RPRE_EFFECTIVE={RPRE25*(1+TCRPRE*(TEMPAMB-25))}
.param LPRE=250n CDC=1m CESR=8m CESL=100n RLEAK=100k RDIS=1k
.param RCOIL_MAIN={12*(1+.00393*(TEMPAMB-25))} LCOIL_MAIN=80m
.param RCOIL_PRE={24*(1+.00393*(TEMPAMB-25))} LCOIL_PRE=60m
.param EPACK=0 ELINK=0

* Nominal fault settings: low series values mean healthy closed conductors.
.param RNEG_COIL_FAULT=10m RPOS_COIL_FAULT=10m RPRE_COIL_FAULT=10m
.param RPOS_PATH_FAULT=10u RDIS_PATH_FAULT=10u
.param F_POS_WELD=0 F_PRE_WELD=0

.include DCLINK_PHYSICAL_PLANT.inc

.tran 0 6 0 5u uic
.options plotwinsize=0 reltol=.001 abstol=100n vntol=100u method=gear

.meas tran I_PRE_PEAK MAX abs(I(RPRE_PATH)) FROM=2m TO=400m
.meas tran T_PRE_CONTACT WHEN V(PRE_MECH)=6 RISE=1
.meas tran T_MAIN_CMD WHEN V(POS_GATE)=2.5 RISE=1
.meas tran T_MAIN_CONTACT WHEN V(POS_MECH)=6 RISE=1
.meas tran T_RUN_OK WHEN V(RUN_OK)=4 RISE=1
.meas tran VDC_AT_CLOSE FIND V(DCPLUS,DCMINUS) WHEN V(POS_MECH)=6 RISE=1
.meas tran VPACK_AT_CLOSE FIND V(HVP_BUS) WHEN V(POS_MECH)=6 RISE=1
.meas tran V_RATIO_CLOSE PARAM VDC_AT_CLOSE/VPACK_AT_CLOSE
.meas tran E_PRE INTEG I(RPRE_PATH)*I(RPRE_PATH)*RPRE_EFFECTIVE FROM=2m TO=400m
.meas tran I_NEG_COIL_PK MAX abs(I(RNEG_COIL_FAULT)) FROM=0 TO=1
.meas tran I_POS_COIL_PK MAX abs(I(RPOS_COIL_FAULT)) FROM=0 TO=1
.meas tran I_PRE_COIL_PK MAX abs(I(RPRE_COIL_FAULT)) FROM=0 TO=400m
.meas tran T_TO_60 TRIG V(DIS_REQ) VAL=2.5 RISE=1
+ TARG V(DCPLUS,DCMINUS) VAL=60 FALL=1
.meas tran VDC_5S FIND V(DCPLUS,DCMINUS) AT=5

.end
