* CR-004 fault injection campaign
* FAULT=0 nominal
* 1 precharge open, 2 precharge short, 3 positive main welded
* 4 active discharge open, 5 positive main fails open, 6 negative main fails open
* 7 Vdc sensor high bias, 8 Vdc sensor low bias, 9 capacitor ESR high

.param FAULT=0 VPACK=800 CDC=1m RPRE25=92 TEMPAMB=25
.param RSOURCE=47m RBATP={.55*RSOURCE} RBATN={.20*RSOURCE} LBAT=1u RHAR={.25*RSOURCE} LHAR=2u
.param TCRPRE=100u RPRE_BASE={RPRE25*(1+TCRPRE*(TEMPAMB-25))}
.param RPRE={if(FAULT==1,1G,if(FAULT==2,50m,RPRE_BASE))}
.param CESR={if(FAULT==9,80m,8m)} CESL=100n RLEAK=100k
.param RCONT=850u LCONT=80n RDIS_BASE=1k
.param RDIS={if(FAULT==4,1G,RDIS_BASE)} RDISON=.8
.param EPACK=0 ELINK={if(FAULT==7,.15,if(FAULT==8,-.15,0))}
.param THRESH=.93 TCMD=2.5m TNEG=2m TPRE=12m TSHUT=1 TDIS=1.002

Vbat batt_p batt_n {VPACK}
Rbatp batt_p bp1 {RBATP}
Lbat bp1 bp2 {LBAT}
Rhar bp2 bp3 {RHAR}
Lhar bp3 HVP {LHAR}
Rbatn batt_n HVN {RBATN}
Rneg_sw HVN neg1 R={if(V(NEG_DRV)>2.5,0.5m,1G)}
Rneg_c neg1 neg2 {RCONT}
Lneg neg2 DCMINUS {LCONT}
Rpos_sw HVP pos1 R={if(V(POS_DRV)>2.5,0.5m,1G)}
Rpos_c pos1 pos2 {RCONT}
Lpos pos2 DCPLUS {LCONT}
Rweld HVP DCPLUS R={if(FAULT==3,RCONT,1G)}
Rpre_sw HVP pre1 R={if(V(PRE_CMD)>2.5,0.5m,1G)}
Rpre pre1 pre2 {RPRE}
Lpre pre2 DCPLUS 250n
Lesl DCPLUS cap_esr {CESL}
Resr cap_esr cap_node {CESR}
Cdc cap_node DCMINUS {CDC} IC=0
Rleak DCPLUS DCMINUS {RLEAK}
Rdis_sw DCPLUS dis1 R={if(V(DIS_CMD)>2.5,RDISON,1G)}
Ractive dis1 DCMINUS {RDIS}
Bpack_sns VPACK_SNS 0 V=V(HVP,HVN)*(1+EPACK)
Bdc_sns VDC_SNS 0 V=V(DCPLUS,DCMINUS)*(1+ELINK)
Bneg_cmd NEG_CMD 0 V=if(time>=TNEG && time<TSHUT,5,0)
Bpos_raw POS_RAW 0 V=if(time>=TPRE && time<TSHUT && V(VPACK_SNS)>100 && V(VDC_SNS)>=THRESH*V(VPACK_SNS),5,0)
Rpos_delay POS_RAW POS_FILT 1k
Cpos_delay POS_FILT 0 {TCMD/(1000*ln(2))}
Bpos_cmd POS_CMD 0 V=if(V(POS_FILT)>2.5,5,0)
Bpre_cmd PRE_CMD 0 V=if(time>=TPRE && time<TSHUT && V(POS_CMD)<2.5,5,0)
Bdis_cmd DIS_CMD 0 V=if(time>=TDIS,5,0)
Bneg_drv NEG_DRV 0 V=if(FAULT==6,0,V(NEG_CMD))
Bpos_drv POS_DRV 0 V=if(FAULT==5,0,V(POS_CMD))
Rcmd1 NEG_CMD 0 1G
Rcmd2 POS_CMD 0 1G
Rcmd3 PRE_CMD 0 1G
Rcmd4 DIS_CMD 0 1G
Rcmd5 NEG_DRV 0 1G
Rcmd6 POS_DRV 0 1G
Rcmd7 POS_RAW 0 1G
Rcmd8 POS_FILT 0 1G

.tran 0 6 0 5u UIC
.options plotwinsize=0 reltol=.001 abstol=1u vntol=100u method=gear
.meas tran I_PRE_PEAK MAX abs(I(Rpre)) FROM={TPRE} TO={TSHUT}
.meas tran VDC_350MS FIND V(DCPLUS,DCMINUS) AT=350m
.meas tran VDC_1100MS FIND V(DCPLUS,DCMINUS) AT=1.1
.meas tran VDC_5S FIND V(DCPLUS,DCMINUS) AT=5
.meas tran I_BAT_PEAK MAX abs(I(Vbat)) FROM=0 TO=1
.step param FAULT list 0 1 2 3 4 5 6 7 8 9
.end
