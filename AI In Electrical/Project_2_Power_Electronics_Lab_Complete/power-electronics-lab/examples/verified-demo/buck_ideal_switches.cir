* Original ideal-switch synchronous buck exploration deck
* Fixed PWM; this is separate from the Python PI-controlled averaged model.
* LTspice execution has not been performed by the bundle builder.
.param VIN=48.0 VOUT=12.0 POUT=1000.0
.param FS=100000.0 TS=1/FS DUTY=0.253472222222 TD=1e-07
VBAT VIN 0 {VIN}
VGH GH 0 PULSE(0 10 {TD} 1n 1n {DUTY*TS-2*TD} {TS})
VGL GL 0 PULSE(0 10 {DUTY*TS+TD} 1n 1n {(1-DUTY)*TS-2*TD} {TS})
SH VIN SW GH 0 HIGH
SL SW 0 GL 0 LOW
DH SW VIN BODY
DL 0 SW BODY
L1 SW LX 4e-05 IC=41.666666666666664
RDC LX OUT 0.001
RESR OUT CAP 0.012
C1 CAP 0 0.0022 IC={VOUT}
BLOAD OUT 0 I=V(OUT)*if(time<20m,0.5,1)*POUT/(VOUT*VOUT)
.model HIGH SW(Ron=0.001 Roff=1e9 Vt=5 Vh=0.1)
.model LOW SW(Ron=0.001 Roff=1e9 Vt=5 Vh=0.1)
.model BODY D(Is=1n Rs=1m N=1)
.tran 0 80m 0 {TS/30} UIC
.meas TRAN VOUT_AVG AVG V(OUT) FROM 60m TO 80m
.meas TRAN VOUT_MAX MAX V(OUT) FROM 20m TO 40m
.meas TRAN VOUT_MIN MIN V(OUT) FROM 20m TO 40m
.meas TRAN IL_MAX MAX I(L1) FROM 0 TO 80m
.end
