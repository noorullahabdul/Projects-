* SPWM SIC V4 - DIRECT NGSPICE REFERENCE
.include SPWM_SIC_V4_MODELS.lib

VDC DC_POS 0 750
RDC_ESR DC_POS DC_CAP 0.05
CDC DC_CAP 0 2200u

XSPWM 0 PWM_AH PWM_AL PWM_BH PWM_BL PWM_CH PWM_CL REF_A REF_B REF_C CARRIER SPWM_CORE PARAMS: FOUT=50 FSW=40k MA=0.85 ACAR=1 VLOGIC=5 DEADBAND=0.04 ROUT=10

XLEGA DC_POS 0 PWM_AH PWM_AL VPOLE_A VGS_AH VGS_AL SIC_PHASE_LEG
XLEGB DC_POS 0 PWM_BH PWM_BL VPOLE_B VGS_BH VGS_BL SIC_PHASE_LEG
XLEGC DC_POS 0 PWM_CH PWM_CL VPOLE_C VGS_CH VGS_CL SIC_PHASE_LEG

LA VPOLE_A VA_FILT 2m
RLA VA_FILT N_FLOAT 20
RDA VA_FILT NDA 2
CFA NDA N_FLOAT 10u

LB VPOLE_B VB_FILT 2m
RLB VB_FILT N_FLOAT 20
RDB VB_FILT NDB 2
CFB NDB N_FLOAT 10u

LC VPOLE_C VC_FILT 2m
RLC VC_FILT N_FLOAT 20
RDC VC_FILT NDC 2
CFC NDC N_FLOAT 10u

RNEUT N_FLOAT 0 1Meg

.options method=gear reltol=1e-3 abstol=1p vntol=1u gmin=1e-10
.tran 200n 5m 0 200n

.plot tran V(REF_A) V(REF_B) V(REF_C) V(CARRIER)
.plot tran V(PWM_AH) V(PWM_AL) V(VPOLE_A)
.plot tran V(VA_FILT,N_FLOAT) V(VB_FILT,N_FLOAT) V(VC_FILT,N_FLOAT)

.end
